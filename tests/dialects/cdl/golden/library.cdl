* Generated by spicule

* origin: cells/inv.py:8
.SUBCKT inv a y vdd vss nfin=2
Mmn y a vss vss nch l=16e-9 nfin='nfin' m=1
Mp0 y a vdd vdd pch l=16e-9 nfin='(nfin)**(2)/2'
.ENDS inv

.SUBCKT bank d<3> d<2> d<1> d<0> q<1> q<0> vdd vss
Xu0 d<3> d<2> d<1> d<0> q<1> q<0> nc_u0_0 nc_u0_1 latch4
Xxi d<0> q<0> vdd vss inv nfin=4
.ENDS bank

.END
