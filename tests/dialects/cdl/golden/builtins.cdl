* Generated by spicule

.SUBCKT rc a b
Rr1 a b 1e3
Cc1 b a 10e-15
.ENDS rc

.END
