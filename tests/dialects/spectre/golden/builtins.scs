// Generated by spicule
simulator lang=spectre

// top: tb_rc
v0 (vin 0) vsource type=dc dc=800e-3
r0 (vin 0) resistor r=1e3 isnoisy=no
