// Generated by spicule
simulator lang=spectre

// origin: cells/inv.py:8
subckt inv (a y vdd vss)
    parameters nfin=2
    mn (y a vss vss) nch nfin=nfin
    mp (y a vdd vdd) pch nfin=2*nfin l=max(16e-9, pow(2, 3)*2e-9)
ends inv

subckt buf (a y vdd vss)
    i0 (a mid vdd vss) inv
    // origin: cells/buf.py:14
    i1 (mid y vdd vss) inv m=2
ends buf

subckt bank (d\<3\> d\<2\> d\<1\> d\<0\> q\<1\> q\<0\>)
    u0 (d\<3\> d\<2\> d\<1\> d\<0\> q\<1\> q\<0\> nc_u0_0 nc_u0_1) latch4
ends bank

// top: tb
dut (in out vdd 0) buf
b0 (d\<0\> d\<1\> d\<2\> d\<3\> q\<1\> q\<0\>) bank
