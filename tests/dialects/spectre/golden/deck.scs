// Generated by spicule
simulator lang=spectre

parameters w=700e-3 x=2*w
include "models.scs" section=tt
include "more models.scs"

// top: tb
r0 (a 0) resistor r=x

ic a=0
statistics {
    process {
    }
}

opts options temp=27 reltol=100e-6
save a r0:1

op dc
tr tran stop=1e-9 errpreset=conservative
// between the analyses
sw sweep param=w values=[600e-3 -800e-3 w -w (1 + w) (-(1 + w))] {
    tr tran stop=1e-9
    // in the sweep
}
mc montecarlo numruns=100 variations=mismatch {
    op dc
}
