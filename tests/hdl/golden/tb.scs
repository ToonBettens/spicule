// Generated by spicule
simulator lang=spectre

subckt inv (a y vdd vss)
    parameters nfin=2
    mn (y a vss vss) nch nfin=nfin
    mp (y a vdd vdd) pch nfin=2*nfin l=max(16e-9, pow(nfin, 2)*4e-9)
ends inv

// top: Tb
dut (a y vdd 0) inv nfin=4
vs (vdd 0) vsource type=dc dc=800e-3
va (a 0) vsource type=pulse val0=0 val1=800e-3 period=1e-9
cl (y 0) capacitor c=1e-15
