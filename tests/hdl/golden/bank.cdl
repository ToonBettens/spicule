* Generated by spicule

.SUBCKT inv a y vdd vss nfin=2 m=1
Mmn y a vss vss nch nfin='nfin'
Mmp y a vdd vdd pch nfin='2*nfin' l='max(16e-9, (nfin)**(2)*4e-9)'
.ENDS inv

.SUBCKT bank d<3> d<2> d<1> d<0> q<0> q<1> q<2> q<3> en vdd vss
Xu0 d<3> d<2> en nc_u0_0 mid<3> mid<2> mid<1> mid<0> latch4
Xu1 mid<0> mid<1> mid<2> mid<3> q<0> q<1> q<2> q<3> latch4
Xx0 en nc_x0_0 vdd vss inv nfin=3 m=2
.ENDS bank

.END
